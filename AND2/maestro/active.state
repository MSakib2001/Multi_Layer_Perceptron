ADE simulation setup
Test ECE555_AND2_1: ECE555/AND2/schematic, simulator hspiceD
Run mode: Single Run, Sweeps and Corners
