ADE simulation setup
Run mode: Single Run, Sweeps and Corners
Tests:
  ECE555_AND2_1: ECE555/AND2/schematic, simulator hspiceD
